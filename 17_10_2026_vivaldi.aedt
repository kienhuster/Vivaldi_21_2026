# Ansys Electronics Desktop project, version 2021.2
materials:
  vacuum: permittivity=1
  aluminum: permeability=1.000021 conductivity=38000000
  copper: permeability=0.999991 conductivity=58000000

design dual_pol_vivaldi_patch_Wflare_20 (HFSS, DrivenModal, model units mm)
variables:
  L_flare_1 = 40mm
  slot_t_L = 6.4mm+them
  L_flare = L_flare_1+slot_t_L
  aperture_w = 20mm
  slot_feed_w = 0.5mm
  r_flare = (1/L_flare)*ln(aperture_w/slot_feed_w)
  deg_slot_t = 21deg
  z_feed = ((slot_feed_w/2)*exp((slot_t_L)*r_flare) +slot_feed_w/2)*sin(deg_slot_t)+slot_t_L*(1-cos(deg_slot_t))
  x_feed = ((slot_feed_w/2)*exp((slot_t_L)*r_flare) +slot_feed_w/2)*cos(deg_slot_t)+slot_t_L*(sin(deg_slot_t))-(slot_feed_w/2)*exp((slot_t_L)*r_flare)
  h3_slot_feed = 1mm
  h2 = 2.6mm
  cavity_w = 1.4mm
  cavity_L = 5mm
  h_de = 2mm
  L_patch = L_flare_1+slot_t_L-z_feed+h3_slot_feed+slot_feed_w+h_de
  r_cabin = 0.15mm
  h_cabin = h_de+slot_feed_w
  positionx = 0.15mm
  r_cabmid = 0.35mm
  h_cabout = h_cabin-slot_feed_w
  h_cabmid = h_cabin-slot_feed_w
  r_cabout = 0.5mm
  de_L = aperture_w+thickness
  de_W = aperture_w+thickness
  lamda = 60mm
  h_box = lamda/2+L_patch
  scan_phi = 0deg
  scan_theta = 0deg
  thickness = 2mm
  them = 0mm
  c2 = 0mm
  alpha = 0deg
geometry:
  coordinate_system slot_feed_td = origin=(-x_feed, 0mm, z_feed) x=(1mm, 0mm, 0mm) y=(0mm, 1mm, 0mm)
  cable_in [copper] = cylinder(axis=Z, base_centre=(-positionx+slot_feed_w+h2, 0mm, -h3_slot_feed), radius=r_cabin, height=-h_cabin) in slot_feed_td
  coordinate_system patch_td = origin=(aperture_w/2, 0mm, L_flare) x=(1mm, 0mm, 0mm) y=(0mm, 1mm, 0mm)
  coordinate_system RelativeCS1 = origin=(0mm, -thickness/2, 0mm) x=(1mm, 0mm, 0mm) y=(0mm, 1mm, 0mm) in patch_td
  cable_in_1 [copper] = cable_in.duplicate_around_axis(axis=Z, angle=-90deg, total=2) in RelativeCS1
  cable_in_2 = cable_in.copy()
  cable_out [copper] = cylinder(axis=Z, base_centre=(-positionx+h2+slot_feed_w, 0mm, -h3_slot_feed-slot_feed_w), radius=r_cabout, height=-h_cabout) in slot_feed_td
  cable_out_1 [copper] = cable_out.duplicate_around_axis(axis=Z, angle=-90deg, total=2) in RelativeCS1
  cable_out_2 = cable_out.copy()
  cable_mid = cylinder(axis=Z, base_centre=(-positionx+h2+slot_feed_w, 0mm, -h3_slot_feed-slot_feed_w), radius=r_cabmid, height=-h_cabout) in slot_feed_td
  cable_mid_1 = cable_mid.duplicate_around_axis(axis=Z, angle=-90deg, total=2) in RelativeCS1
  cable_mid_2 = cable_mid.copy()
  cable_out.subtract(cable_mid)
  port1 = circle(normal=Z, centre=(-positionx+slot_feed_w+h2, 0mm, -h3_slot_feed-h_cabin), radius=r_cabmid) in slot_feed_td
  port2 = port1.duplicate_around_axis(axis=Z, angle=-90deg, total=2) in RelativeCS1
  Vivaldi_1 [aluminum] = rectangle(corner=(0mm, 0mm, 0mm), z_size=-L_patch, x_size=-aperture_w) in patch_td
  coordinate_system slot_t_td = origin=((slot_feed_w/2)*exp(slot_t_L*r_flare), 0, slot_t_L) x=(1mm, 0mm, 0mm) y=(0mm, 1mm, 0mm)
  EquationSurface1 = equation_based_surface(XuvFunction=_v*((slot_feed_w/2)*exp((_u)*r_flare)) YuvFunction=0 ZuvFunction=_u uStart=0 uEnd=L_flare vStart=-1 vEnd=1)
  EquationSurface2 = equation_based_surface(XuvFunction=_v*((slot_feed_w/2)*exp((_u)*r_flare)) YuvFunction=0 ZuvFunction=_u uStart=0 uEnd=slot_t_L vStart=-1 vEnd=1)
  EquationSurface2_1 = EquationSurface2.copy()
  EquationSurface1.subtract(EquationSurface2_1)
  EquationSurface2.rotate(axis=Y, angle=deg_slot_t) in slot_t_td
  Rectangle1 = rectangle(corner=(0mm, 0mm, 0mm), z_size=-h3_slot_feed, x_size=slot_feed_w) in slot_feed_td
  Rectangle2 = rectangle(corner=(0mm, 0mm, -h3_slot_feed), z_size=-slot_feed_w, x_size=slot_feed_w+h2+cavity_w) in slot_feed_td
  Rectangle3 = rectangle(corner=(slot_feed_w+h2, 0mm, -(h3_slot_feed+slot_feed_w)), z_size=cavity_L, x_size=cavity_w) in slot_feed_td
  EquationSurface1.unite(EquationSurface2, Rectangle1, Rectangle2, Rectangle3)
  Vivaldi_1.subtract(EquationSurface1)
  Vivaldi_1.thicken(thickness, both sides)
  Vivaldi_2 = Vivaldi_1.duplicate_around_axis(axis=Z, angle=-90deg, total=2) in RelativeCS1
  Vivaldi_2.move(0mm, thickness, 0mm) in RelativeCS1
  Box1 = box(corner=(0mm, 0mm, 0mm), size=(thickness, thickness, -L_patch)) in RelativeCS1
  De = box(corner=((de_L+thickness)/2, -(de_W-aperture_w)/2, z_feed-h3_slot_feed-slot_feed_w), size=(-de_L, de_W, -h_de))
  Vivaldi_1.unite(Vivaldi_2, Box1, De)
  cable_in_1.move(0mm, thickness, 0mm) in RelativeCS1
  cable_in_1_1 = cable_in_1.copy()
  cable_mid_1.move(0mm, 2mm, 0mm) in RelativeCS1
  cable_mid_1_1 = cable_mid_1.copy()
  cable_out_1.move(0mm, thickness, 0mm) in RelativeCS1
  cable_out_1_1 = cable_out_1.copy()
  Vivaldi_1.subtract(cable_in_2, cable_in_1_1, cable_mid_2, cable_mid_1_1, cable_out_2, cable_out_1_1)
  cable_out_1.subtract(cable_mid_1)
  port2.move(0mm, thickness, 0mm) in RelativeCS1
  RadiatingSurface [vacuum] = region(absolute_offset=20mm on all sides)
boundaries and excitations:
  Open1: Radiation Objects=RadiatingSurface
  1: Lumped Port Objects=port1 Modes{Mode1{IntLine{middle of port1.edge(1 of 1) -> middle of cable_in.edge(1 of 2)} CharImp=Zpi RenormImp=50ohm}} Impedance=50ohm
  2: Lumped Port Objects=port2 Modes{Mode1{IntLine{middle of port2.edge(1 of 1) -> middle of cable_in_1.edge(1 of 2)} CharImp=Zpi RenormImp=50ohm}} Impedance=50ohm
setups:
  Setup1: HfssDriven Frequency=5GHz MaxDeltaS=0.02 MaximumPasses=50 MinimumPasses=5 MinimumConvergedPasses=3 PercentRefinement=10 BasisOrder=1 PortAccuracy=2
    sweep Sweep: 5GHz to 20GHz step 0.25GHz; Type=Discrete SaveFields SaveRadFields
source amplitudes:
  1:1: 1W 0deg
  2:1: 0W 0deg
optimetrics:
  ParametricSetup1: Parametric Sim._Setups=[Setup1]
    sweep scan_theta: LIN 30deg 45deg 15deg
  ParametricSetup2: Parametric Sim._Setups=[Setup1]
    sweep positionx: LIN 0.15mm 2.45mm 1.15mm
  ParametricSetup3: Parametric Sim._Setups=[Setup1]
    sweep cavity_w: LIN 0.7mm 1.4mm 0.7mm
    sweep cavity_L: LIN 4mm 5mm 0.5mm
  ParametricSetup4: Parametric Sim._Setups=[Setup1]
    sweep L_flare_1: LIN 15mm 23mm 4mm
  ParametricSetup5: Parametric Sim._Setups=[Setup1]
    sweep them: LIN -1mm 1mm 1mm
  ParametricSetup6: Parametric Sim._Setups=[Setup1]
    sweep h2: LIN 2mm 4mm 0.5mm
radiation setups:
  3D: Infinite Sphere Theta=0deg..180deg step 2deg Phi=-180deg..180deg step 2deg
  Elevation: Infinite Sphere Theta=-180deg..180deg step 1deg Phi=0deg..90deg step 90deg
  Azimuth: Infinite Sphere Theta=90deg..90deg step 0deg Phi=-180deg..180deg step 1deg
reports:
  S21: dB(S(2,1)) vs Freq on Setup1 : Sweep [cavity_w=all cavity_L=all positionx=all scan_theta=all]; dB(S(3,2)) vs Freq on Setup1 : Sweep [h2=all cavity_w=all cavity_L=all positionx=all scan_theta=all]; markers MY1 at y=-15
  S11: dB(S(1,1)) vs Freq on Setup1 : Sweep [L_flare_1=all aperture_w=all slot_feed_w=0.5mm,0.6mm cavity_w=all cavity_L=all positionx=all scan_theta=all them=all]; markers MY1 at y=-10
  Gain Plot 2: dB(GainTotal) vs Phi, Theta on Setup1 : Sweep, 3D [Freq=6GHz L_flare_1=40mm aperture_w=20mm h2=2.6mm cavity_w=1.4mm cavity_L=5mm positionx=0.15mm scan_theta=0deg them=0mm]
  Realized Gain Plot 1: dB(RealizedGainTotal) vs Freq on Setup1 : Sweep, Elevation [Phi=0deg Theta=18deg L_flare_1=all aperture_w=all h2=all cavity_w=all cavity_L=all positionx=all scan_theta=all them=all]; markers MY1 at y=4.13025
  Realized Gain Plot 3: dB(RealizedGainTotal) vs Phi, Theta on Setup1 : Sweep, 3D [Freq=18GHz L_flare_1=40mm aperture_w=20mm h2=2.5mm cavity_w=1.4mm cavity_L=5mm positionx=0.15mm scan_theta=0deg them=0mm]
  Realized Gain Plot 4: dB10normalize(RealizedGainTotal) vs Theta on Setup1 : Sweep, Elevation [Phi=90deg Freq=18GHz L_flare_1=all aperture_w=all h2=all cavity_w=all cavity_L=all positionx=all scan_theta=all them=all]; markers MY1 at y=0, MY2 at y=-33.9353
  Realized Gain Plot 5: dB(RealizedGainTotal) vs Theta on Setup1 : Sweep, Elevation [Phi=90deg Freq=18GHz L_flare_1=all aperture_w=14mm cavity_w=all cavity_L=all positionx=all scan_theta=all them=all]; markers m2 at -17deg, m3 at 1deg, m4 at -14deg, m5 at -29deg, m6 at 17deg
  Axial Ratio Plot 1: dB(AxialRatioValue) vs Freq on Setup1 : Sweep, 3D [Phi=0deg Theta=0deg L_flare_1=all aperture_w=all cavity_w=all cavity_L=all positionx=all scan_theta=all them=all]
  Realized Gain Plot 6: dB(RealizedGainTotal) vs Phi, Theta on Setup1 : Sweep, 3D [Freq=6GHz L_flare_1=90mm h2=2.6mm cavity_w=1.4mm cavity_L=5mm positionx=0.15mm scan_theta=0deg them=0mm]
